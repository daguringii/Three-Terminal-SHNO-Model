// VerilogA for ThreeTerminalModel, ThreeTerminalSHNO, veriloga

/* Note: Please cite the following publication:
   D. I. Albertsson, M. Zahedinejad, J. Åkerman, S. Rodriguez and A. Rusu,
   "Compact Macrospin-Based Model of Three-Terminal Spin-Hall Nano Oscillators,"
   in IEEE Transactions on Magnetics, vol. 55, no. 10, pp. 1-8, Oct. 2019,
   Art no. 4003808, doi: 10.1109/TMAG.2019.2925781.*/

// Any feedback is greatly appreciated: dial@kth.se

`include "constants.vams"
`include "disciplines.vams"

module ThreeTerminalSHNO(I_MTJ,I_HM,GND);

inout GND;
inout I_MTJ;
inout I_HM;
electrical GND, I_MTJ, I_HM;

/***************************************/
/***************Constants***************/
/***************************************/

`define magnetic_constant 4*`M_PI*1e-7  //magnetic constant
`define Temperature 300 //room temperature (K)
`define g_factor 2.00232 //electron g-factor (dimensionless)
`define mu_B 9.274e-24 //(J/T=N*m/(N/(A*m))=A*m^2)
`define mu_B_CGS 9.274e-21 // erg/G
`define h_bar_CGS 1.055e-27 // erg*S
`define k_B_CGS 1.38e-16 //[erg/K]

/***************************************/
/**************Parameters***************/
/***************************************/

parameter real R_p = 4465;//parallel resistance
parameter real R_ap = 5150;//anti-parallel resistance
parameter real R_HM = 1800;//Tantulum resistance from mid to GND
parameter real M_s_delta = 730; //(Oe/V) change in perpendicular anisotropy as a function of voltage

parameter I_hpos_ap = 450e-6;//(A) TMR fitting parameter for I>0
parameter I_hneg_ap = -360e-6;//(A) TMR fitting parameter for I<0
parameter I_hpos_p = 800e-6;
parameter I_hneg_p = -750e-6;

parameter real phi_ext_deg =7; //(degrees) in-plane angle of H_ext CCW from easy-axis which lies on the x-axis
parameter real H_ext = 163; //(Oe) applied field
parameter real H_int = 80;//(Oe) interlayer coupling field between free and fixed layers
parameter real H_A = 0; //(Oe) anisotropy field
parameter real H_PA = 11400; //(Oe) perpendicular anisotropy field
parameter real H_s = 12500;//(Oe)saturation magnetization
parameter real t_free=1.5e-9;//(m) thickness of free layer
parameter real A_MTJ = `M_PI/4*50e-9*180e-9;//(m^2)area of magnetic tunnel junction (width*length)
parameter real t_HM = 6e-9;//(m) thickness of HM
parameter real w_HM = 1.2e-6;//(m) widht of HM
parameter real SHA = 0.15; //dimensionless spin-hall angle
parameter real alpha_G = 0.05; //Gilbert damping const
parameter real Q = 9.31; //nonlinear damping
parameter real eta_0 = 0.05; //effective noise power
parameter real delta_t=10e-12;
parameter real sim_time =1e-6;
parameter integer num_step =sim_time/delta_t;

/*************************************/
/************Finding p_bar************/
/*************************************/
analog function real integral_1;
input t_0, eta_0, zeta_0, Q;
real t_0, eta_0,zeta_0, Q;
real y0, y1, x0, x1, step;
integer i, N;
begin
	y0=0;
	x0=t_0;
	step = 0.001;
	N=10/step;
	for(i=0;i<=N;i=i+1)
	begin
		y1=y0+(exp(-x0*(zeta_0+Q)/(Q*Q*eta_0)))/pow(x0,(-(1+Q)*zeta_0/(Q*Q*eta_0)))*step;
		y0=y1;
	      	x1=x0+step;
	      	x0=x1;
    	end
	integral_1 = y0;
end
endfunction

/******************************************************************************/
/************Special case for Q=0 to find p_bar (note:not verified)************/
/******************************************************************************/
analog function real integral_0;
input zeta_0,eta_0;
real zeta_0,eta_0,x,t,tau;
begin
	x = (zeta_0-1)/(sqrt(2*zeta_0*eta_0));
    	t = 1/(1+0.5*abs(x));
    	tau = t*exp(-x*x-1.26551223+1.00002368*t+0.37409196*t*t+0.09678418*t*t*t-0.18628806*t*t*t*t+0.27886807*t*t*t*t*t-1.13520398*t*t*t*t*t*t+1.48851587*t*t*t*t*t*t*t-0.82215223*t*t*t*t*t*t*t*t+0.17087277*t*t*t*t*t*t*t*t*t);
    	if (x>=0) begin
        	integral_0= 1-tau;
    	end else begin
		integral_0= tau-1;
    	end
end
endfunction

analog function real myFunction;
input phi_eff, H_A, phi_ext, H_ext;
real phi_eff, H_A, phi_ext, H_ext;
begin
	myFunction = H_ext*sin(phi_ext)*cos(phi_eff)/sin(phi_eff) -H_A*cos(phi_eff)-H_ext*cos(phi_ext);
end
endfunction

/******************************************************************************/
/************Solve for the effective magnetic field using bisection************/
/******************************************************************************/
analog function real bisecmethod;
input H_A, phi_ext, H_ext;
real phi_eff, H_A, phi_ext, H_ext;
real leftpt, rightpt, epsilon, midpt, rtvalue, midvalue;
begin
//Note: The initial guesses might need to be modified depending on the external field

	leftpt = 0;//initial guess
	rightpt = 3.14;//initial guess
	epsilon = 0.001;//resolution
	while((rightpt-leftpt)>epsilon)
	begin
		midpt = (leftpt+rightpt)/2;
        	rtvalue = myFunction(rightpt, H_A, phi_ext, H_ext);
        	midvalue = myFunction(midpt, H_A, phi_ext, H_ext);
        	if(rtvalue * midvalue >= 0) begin
            		rightpt = midpt;
        	end else begin
            		leftpt = midpt;
        	end
    	end
    	bisecmethod = (rightpt+leftpt)/2;
end
endfunction

/****************************************/
/************Local variables************/
/***************************************/
real M_s, phi_ext, M_s_SI, gyro_ratio, IMTJ, IHM, R_ap_new, R_p_new, A_SH;
real phi_eff, H_eff, H_eff_demag, R_dc, V_MTJ_new, M_s_change_SI, M_s_change_CGS, t_0,H_ext_new, V_MTJ;
real H_x, H_y, H_eff_new, phi_eff_new;
real w_H, w_0, w_M, w_A;
real A,B,V_im,U,u,v,W_1,W_2,T,N, outofplane_angle;
real gamma_g,sigma0, I_th, zeta_0,f0,p_bar,w_g_fund, w_g_second;
real p_0, gamma_plus_p0, Gplus, Gminus, nu_fs,Ep_0, lambda,J_0,J_1,J_2,phi_eff_new_temp,eff;
real phi_prec, R_0, R_prec_fund, R_prec_second,V_dc,V_ac, V_tot, linewidth, phase, phase_acc[0:num_step],fluctuation[0:num_step], A_HM,corrected_SHA, gamma_p,temp;
integer Myseed,j,k;

analog begin
	@(initial_step("tran", "dc"))
   	begin
   		phi_ext = phi_ext_deg/180*`M_PI;
		M_s = H_s/(4*`M_PI);//its : Oe to emu/cm^3 for volume magnetization
		M_s_SI = H_s*1000/(4*`M_PI);//(A/m) SI units
		gyro_ratio = `g_factor*(`mu_B_CGS)/(`h_bar_CGS);
		A_SH = w_HM*t_HM;

		IMTJ=I(I_MTJ,GND);
		IHM =I(I_HM,GND);
		IHM = IHM+IMTJ/2;

		//Fitting for TMR as a function of applied voltage
		if (IMTJ>0) begin
			R_ap_new = R_ap/(1+pow(IMTJ/I_hpos_ap,1.5));
			R_p_new = R_p/(1+pow(IMTJ/I_hpos_p,1.5));
		end else begin
			R_ap_new = R_ap/(1+pow(IMTJ/I_hneg_ap,1.5));
			R_p_new = R_p/(1+pow(IMTJ/I_hneg_p,1.5));
		end

		//Find H_eff
		if(phi_ext == 0) begin
			H_eff = H_ext+H_A;
			phi_eff = 0;
		end else begin
			phi_eff = bisecmethod(H_A, phi_ext, H_ext);
			H_eff = H_ext * sin(phi_ext)/sin(phi_eff);
			//if(phi_eff<0.001) begin
			//	H_eff = H_ext-H_A;
			//	phi_eff = 0;
			//end
		end

		H_x = H_eff*cos(phi_eff)-H_int;
		H_y = H_eff*sin(phi_eff);
		H_eff_new = sqrt(H_x*H_x+H_y*H_y);
		phi_eff_new_temp = atan(H_y/H_x);

		if(phi_eff_new_temp<0.005) begin
			phi_eff_new = phi_eff_new_temp+`M_PI;
		end else begin
			phi_eff_new = phi_eff_new_temp;
		end

		//Find the DC operating point
		R_dc=R_p_new + (R_ap_new-R_p_new)*(sin(phi_eff_new/2)*sin(phi_eff_new/2));
		V_MTJ_new = IMTJ*R_dc;

		//Effective demag field taking into account PMA
		H_eff_demag = 4*`M_PI*M_s - H_PA;
		w_H = gyro_ratio*H_eff_new;
		w_A = gyro_ratio*H_A;
		w_M = gyro_ratio*(H_eff_demag+M_s_delta*V_MTJ_new);
		w_0 = sqrt((w_H-sin(phi_eff_new)*sin(phi_eff_new)*w_A)*(w_H+w_M));

		outofplane_angle= 0;
		A = w_H + 0.5*w_M - 0.5*sin(phi_eff_new)*sin(phi_eff_new)*w_A;
		B = 0.5*w_M + 0.5*sin(phi_eff_new)*sin(phi_eff_new)*w_A;
		V_im = -cos(phi_eff_new)*sin(phi_eff_new)*w_A;
		U = 0.25*((1-3*cos(2*outofplane_angle))*(w_M+w_A/2)-3*cos(outofplane_angle)*cos(outofplane_angle)*cos(2*phi_eff_new)*w_A);
		u = sqrt((A+w_0)/(2*w_0));
		v = B/abs(B) * sqrt((A-w_0)/(2*w_0));
		W_1 = 1.5*(u*u+abs(v)*abs(v))*(u*V_im-v*V_im)-0.5*(u*V_im+v*V_im);
		W_2 = -u*v*(u*V_im-v*V_im);
		T = 0.5*(3*(u*u+abs(v)*abs(v))*(u*u+abs(v)*abs(v))-1)*U+3*u*(u*u+abs(v)*abs(v))*v*B;

		//Nonlinear frequency shift coefficient
		N = (2*w_0/A)*(T-3*(W_1*W_1+W_2*W_2)/w_0);

		gamma_g = alpha_G*(w_H+0.5*w_M-0.5*sin(phi_eff_new)*sin(phi_eff_new)*w_A);
		sigma0 = (`g_factor*`mu_B*SHA)/(2*`P_Q*A_SH*t_free*(H_eff_demag*1000/(4*`M_PI)+M_s_delta*1000/(4*`M_PI)*V_MTJ_new))*cos(phi_eff_new);

		//Threshold current
		I_th = gamma_g/(sigma0);

		//Supercriticality
		zeta_0 = IHM/I_th;

		//Find p_bar
		/*Note that for simplicity, p_bar can be replaced with p_0*/
		t_0 =1;
		if (Q==0) begin
    			f0 = integral_0(zeta_0,eta_0);
    			p_bar = sqrt(2*eta_0/(`M_PI*zeta_0))*(exp(-((zeta_0-1)*(zeta_0-1))/(2*zeta_0*eta_0)))/(1+f0)+(zeta_0-1)/zeta_0;
		end else begin
    			f0 = integral_1(t_0,eta_0, zeta_0, Q);
    			p_bar=(Q*eta_0/(Q+zeta_0))*(1+exp(-(zeta_0+Q)/(Q*Q*eta_0))/f0)+(zeta_0-1)/(zeta_0+Q);
		end

		//Fundmanetal and second harmonic frequency
		w_g_fund = w_0+N*p_bar;
		w_g_second = 2*(w_0+N*p_bar);

		//Find the linewdith
		p_0 = (zeta_0-1)/(zeta_0+Q);
		gamma_plus_p0=gamma_g*(1+Q*p_0);

		Gplus = Q*gamma_g;
		Gminus = -zeta_0*gamma_g;
		nu_fs = N/(Gplus-Gminus);
		gamma_p = (zeta_0-1)*gamma_g;
		lambda = A_MTJ*t_free*1e6*(H_eff_demag+M_s_delta*V_MTJ_new)/(4*`M_PI) * 1/gyro_ratio;
		Ep_0 = lambda*w_0*p_0;

		if((zeta_0-0.85)<0) begin
			linewidth = 2*gamma_g*(1-zeta_0);
		end else begin
			linewidth = (1+nu_fs*nu_fs)*gamma_plus_p0*`k_B_CGS*`Temperature/Ep_0;
		end

		//Calculated the precissional angle and resistance
		phi_prec = 2*asin(sqrt(p_bar));
		J_0 = 0.1667*0.333*cos(phi_prec*0.5)+0.33*cos(sqrt(3)*0.5*phi_prec)+0.1667*cos(phi_prec);
		J_1 = 0.1667*sin(phi_prec*0.5)+0.1667*sin(phi_prec)+sqrt(3)*0.1667*sin(sqrt(3)*0.5*phi_prec);
		J_2 = 0.1667+0.1667*cos(0.5*phi_prec)-0.1667*cos(sqrt(3)*0.5*phi_prec)-0.1667*cos(phi_prec);

		R_0 = (R_ap_new+R_p_new)/2-((R_ap_new-R_p_new)/2*J_0*cos(phi_eff_new));
		R_prec_fund = ((R_ap_new-R_p_new)/R_0)*((R_ap_new-R_p_new)/R_0)*J_1*J_1*sin(phi_eff_new)*sin(phi_eff_new)*R_0/8;
		R_prec_second = (R_ap_new-R_p_new)/R_0*(R_ap_new-R_p_new)/R_0*J_2*J_2*cos(phi_eff_new)*cos(phi_eff_new)*R_0/8;

		//Generate the phase noise
      		Myseed=abs($random%255);
      		phase_acc[0]=0;
      		for (j=0;j<sim_time/delta_t;j=j+1)
      		begin
         		fluctuation[j]=($rdist_normal(Myseed,0,sqrt(linewidth*delta_t)))/delta_t;
         		/*Please note that this fluctuation vector is actually the vector of angular velocity fluctuation!*/
         		if (j>0)
         		begin
            			phase_acc[j]=fluctuation[j-1]*delta_t+phase_acc[j-1];
         		end
         		else begin
            			phase_acc[0]=0;
      			end
         		k=-1;
   		end
	end

   	@(timer(0,delta_t)) //@timer(start, period)
   	begin
      		k=k+1;
  	 end

   	phase=($abstime-(k*delta_t))*fluctuation[k]+phase_acc[k];

	V_dc = V_MTJ_new + R_HM*(IHM+IMTJ);
	V_ac = R_prec_second*cos((w_g_second*$abstime)+phase)*IMTJ+R_prec_fund*cos((w_g_fund*$abstime)+phase)*IMTJ;
	V_tot = V_ac+V_dc;
	V(I_MTJ,GND)<+ V_tot;
	V(I_HM,GND)<+ R_HM*(IHM+IMTJ)+R_HM*IHM;
end

endmodule
